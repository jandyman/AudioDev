.title KiCad schematic
.include "/Users/andy/Documents/Developer/AudioDev/Onboard DSP Board HW/String Preamp Test Board/tlv9001.lib"
.include "/Users/andy/Documents/Developer/AudioDev/Onboard DSP Board HW/String Preamp Test Board/tlv9004.lib"
XU1 /sum_out /sum_out /sum_in /v+ /buf_in Net-_U1B--_ Net-_U1B--_ /filt_out Net-_U1C--_ Net-_U1C-+_ GND /vref /VG /VG TLV9004
R9 Net-_U1B--_ Net-_C7-Pad1_ 100
C7 Net-_C7-Pad1_ /RV3_in 4.7u
C6 GND /buf_in 4.7n
R30 /p2_out /sum_in 22k
R28 /RV3_in GND 10k
R27 /filt_out /buf_in 1
R29 /sum_in /p1_out 22k
C2 Net-_C2-Pad1_ /filt_out 5.6n
R14 /VG Net-_C2-Pad1_ 9.6k
C5 GND /v+ 0.1u
R7 /vref /v+ 10k
R8 GND /vref 10k
C4 GND /vref 0.1u
V2 /v+ GND DC 3.7
R3 /sum_out Net-_C2-Pad1_ 14.7k
R5 /VG Net-_U1C--_ 10k
R6 Net-_U1C--_ /filt_out 15k
R15 /filt_out Net-_R15-Pad2_ 2.2k
C3 Net-_U1C-+_ /VG 5.6n
R4 Net-_C2-Pad1_ Net-_U1C-+_ 5.9k
R12 Net-_R12-Pad1_ Net-_U2--_ 20k
R13 Net-_R13-Pad1_ Net-_U2--_ 20k
R11 Net-_R11-Pad1_ Net-_U2--_ 20k
R10 /Summer/sim_in Net-_U2--_ 20k
XU2 /VG Net-_U2--_ /v+ GND /p1_out TLV9001
C9 GND /v+ 100n
R16 Net-_U2--_ /p1_out 20k
V1 /Summer/sim_in /VG DC 0 SIN( 0 .34 1k 0 0 0 ) AC 1
R19 Net-_R19-Pad1_ Net-_U3--_ 20k
R20 Net-_R20-Pad1_ Net-_U3--_ 20k
R18 Net-_R18-Pad1_ Net-_U3--_ 20k
R17 /Summer1/sim_in Net-_U3--_ 20k
XU3 /VG Net-_U3--_ /v+ GND /p2_out TLV9001
C11 GND /v+ 100n
R23 Net-_U3--_ /p2_out 20k
V3 /Summer1/sim_in /VG DC 0 SIN( 0 .34 1k 0 0 0 ) AC 1
.end
